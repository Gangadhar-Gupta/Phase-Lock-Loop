// VerilogA for PLL_Schematic, D_FF, veriloga

`include "constants.vams"
`include "disciplines.vams"
`include "discipline.h"
`include "constants.h"

// $Date: 1998/09/23 03:13:33 $
// $Revision: 1.2 $
//
//
// Based on the OVI Verilog-A Language Reference Manual, version 1.0 1996
//
//

//--------------------
// d_ff
//
// -  D-type flip flop
//
// vin_d:		[V,A]
// vclk:		[V,A]
// vout_q,vout_qbar:	[V,A]
//
// INSTANCE parameters
//    vlogic_high = output voltage for high [V]
//    vlogic_low  = output voltage for high [V]
//    vtrans      = voltages above this at input are considered high [V]
//    vtrans_clk  = transition voltage of clock [V]
//    tdel, trise, tfall = {usual} [s]
//
// Triggered on the rising edge
//
(* instrument_module *)
module D_FF(vin_d, vclk, vout_q, vout_qbar);
input vclk, vin_d;
output vout_q, vout_qbar;
electrical vout_q, vout_qbar, vclk, vin_d;
parameter real vlogic_high = 1;
parameter real vlogic_low = 0;
parameter real vtrans_clk = 0.5;
parameter real vtrans = 0.5;
parameter real tdel = 1f from [0:inf);
parameter real trise = 1f from (0:inf);
parameter real tfall = 1f from (0:inf);

   integer x;

   analog begin
      @ (cross( V(vclk) - vtrans_clk, +1 ))
         x = (V(vin_d) > vtrans);
         V(vout_q) <+ transition( vlogic_high*x + vlogic_low*!x,
				   tdel, trise, tfall );
         V(vout_qbar) <+ transition( vlogic_high*!x + vlogic_low*x,
				      tdel, trise, tfall );
    end
endmodule
