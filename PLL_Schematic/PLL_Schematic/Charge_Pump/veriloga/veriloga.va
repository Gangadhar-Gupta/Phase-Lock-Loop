// VerilogA for PLL_Schematic, Charge_Pump, veriloga

`include "constants.vams"
`include "disciplines.vams"
`include "discipline.h"
`include "constants.h"

// $Date: 2000/03/13 23:01:48 $
// $Revision: 1.2 $
//
//
// Based on the OVI Verilog-A Language Reference Manual, version 1.0 1996
//
//

//--------------------
// charge_pump
//
// -  Charge pump
//
// vout:		output terminal from which charge pumped/sucked [V,A]
// vsrc: 		source terminal from which charge sourced/sunk  [V,A]
// siginc,sigdec:	Logic signal that control charge pump operation [V,A]
//
// INSTANCE parameters
//    iamp        = charging current magnitude [A]
//    vtrans      = voltages above this at input are considered high [V]
//    tdel, trise, tfall = {usual} [s]
//
// MODEL parameters
//    {none}
//
// This model can source of sink a fixed current, 'iamp'. Its mode
// depends on the values of 'siginc' and 'sigdec';
//
//    When 'siginc' > 'vtrans', 'iamp' Amps are pumped from the output.
//    When 'sigdec' > 'vtrans', 'iamp' Amps are sucked into the output.
//    When both 'siginc' & 'sigdec' in same state - no current sucked/pumped.
//
(* instrument_module *)
module Charge_Pump(siginc, sigdec, vout, vsrc);
input siginc, sigdec;
inout vout, vsrc;
electrical siginc, sigdec, vout, vsrc;
parameter real iamp=0.5m from [0:inf);
parameter real vtrans = 2.5;
parameter real tdel=0 from [0:inf);
parameter real trise=1n from (0:inf);
parameter real tfall=1n from (0:inf);

   real iout_val;

   //
   // Current multiplier - returns direction that charge should be pumped
   //
   analog function real i_mult;
   input inc;
   input dec;
   input vtrans;
   real inc;
   real dec;
   real vtrans;

      integer inc_high;
      integer dec_high;

   begin
      inc_high = inc > vtrans;
      dec_high = dec > vtrans;
      i_mult = 0.0;
      if (inc_high == dec_high) begin
         i_mult = 0.0;
      end else if (inc_high) begin
         i_mult = 1.0;
      end else if (dec_high) begin
         i_mult = -1.0;
      end
   end
   endfunction

   analog begin
      @ ( initial_step ) begin
	 iout_val = iamp*i_mult(V(siginc), V(sigdec), vtrans);
      end

      @ (cross(V(siginc) - vtrans, 0)) begin
         iout_val = iamp*i_mult(V(siginc),V(sigdec),vtrans);
      end
      @ (cross(V(sigdec) - vtrans, 0)) begin
         iout_val = iamp*i_mult(V(siginc),V(sigdec),vtrans);
      end

      I(vsrc, vout) <+ transition(iout_val,tdel,trise,tfall);
   end
endmodule
